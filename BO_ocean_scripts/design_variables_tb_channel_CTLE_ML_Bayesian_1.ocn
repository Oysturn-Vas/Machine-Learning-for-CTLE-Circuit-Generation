desVar(	  "wireopt" 19	)
desVar(	  "bitperiod" "1/56G"	) ; Signal input frequency
desVar(	  "V_one" 0.9	)
desVar(	  "V_zero" 0.5	)
desVar(	  "Vin_AC" 1	)
desVar(	  "Vin_DC" 0.7	)
desVar(	  "L" 20n	)
desVar(	  "Rsource" 0	)
desVar(	  "Rload" 50	)
; Actual varying parameters
desVar(	  "fW" "3.13877u"	)
desVar(	  "current" "1.84126m"	)
desVar(	  "ind" "0"	)
desVar(	  "Rd" "467.697"	)
desVar(	  "Cs" "1p"	)
desVar(	  "Rs" "10"	)
